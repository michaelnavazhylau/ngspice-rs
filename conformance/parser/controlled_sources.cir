Linear controlled-source parser reference
* Leading gains are applied after named setters; G/F multiply a gain by an
* earlier m only. Parenthesized controls and the HSPICE keyword are accepted.
vin in 0 dc 2
vb b 0 dc 1
rin in 0 1k
e1 o1 0 in 0 3
e2 o2 0 (in, b) gain=4
e3 o3 0 vcvs in b {2*5}
g1 0 o4 in 0 1m
g2 0 o5 (in) (0) 2m m=3
g3 0 o6 in 0 gain=2m m=3
g4 0 o7 vccs in 0 5m
f1 0 o8 vin 2
f2 0 o9 vin 1 m=2 gain=3
f3 0 o10 cccs vin 4
h1 o11 0 vin 100
h2 o12 0 e1 gain=50
h3 o13 0 ccvs (vin) 7
re1 o1 0 1k
re2 o2 0 1k
re3 o3 0 1k
rg1 o4 0 1k
rg2 o5 0 1k
rg3 o6 0 1k
rg4 o7 0 1k
rf1 o8 0 1k
rf2 o9 0 1k
rf3 o10 0 1k
rh1 o11 0 1k
rh2 o12 0 1k
rh3 o13 0 1k
.op
.end
