BJT latch operating point by gillespie_src (noopiter, srcsteps=1)
* #106: noopiter skips direct Newton; gillespie_src is the only strategy.
vcc vcc 0 dc 5
rc1 vcc c1 1k
rc2 vcc c2 1.2k
rb1 c1 b2 10k
rb2 c2 b1 10k
rx1 b1 0 4.7k
rx2 b2 0 4.7k
q1 c1 b1 0 qmod
q2 c2 b2 0 qmod
.model qmod npn(is=1e-14 bf=100)
.options reltol=1e-8 noopiter gminsteps=0 srcsteps=1
.op
.end
