MESA level 4 transient: the cas/cbs gate capacitances through a pulse
vdd 1 0 dc 3
vg 3 0 dc 0 pulse(-1.5 0.5n 0.5n 0.1n 0.1n 1n 4n)
z1 1 2 0 n4 l=1u w=20u
r1 1 2 1k
.model n4 nmf level=4 rd=31 rs=31 mu=0.3 gamma=2.5 nmax=4e16
+ cas=0.9 cbs=1.1 epsi=1.142189e-10
.options reltol=1e-6 vntol=1e-10 abstol=1e-14
.tran 0.05n 3n
.end
