BSIM4 CMOS inverter chain: transient
* #90: BSIM4's default parameter set (bsim4/b4set.c) with the selectors
* below, a 0.1 um device that switches like a real process.
* Two inverters, the NMOS with NQS charge (trnqsmod=1).
vdd dd 0 1.2
vin in 0 pulse(0 1.2 0.1n 20p 20p 0.4n 1n)
mp1 o1 in dd dd pch l=0.1u w=2u ad=2e-13 as=2e-13 pd=2.4u ps=2.4u
mn1 o1 in 0 0 nch l=0.1u w=1u ad=1e-13 as=1e-13 pd=1.4u ps=1.4u
mp2 o2 o1 dd dd pch l=0.1u w=2u ad=2e-13 as=2e-13 pd=2.4u ps=2.4u
mn2 o2 o1 0 0 nch l=0.1u w=1u ad=1e-13 as=1e-13 pd=1.4u ps=1.4u
c1 o1 0 2f
c2 o2 0 5f
.model nch nmos level=54 version=4.8.3 rgatemod=1 rbodymod=1 igcmod=1 igbmod=1
+ xrcrg1=12 xrcrg2=5 rshg=0.4 rbpb=5 rbpd=15 rbps=15 rbdb=15 rbsb=15
+ cgso=1.5e-10 cgdo=1.5e-10 cgbo=1e-11 jss=1e-4 cjs=1e-3 cjsws=2e-10
+ trnqsmod=1
.model pch pmos level=54 version=4.8.3 rdsmod=1 rdsw=200
+ cgso=1.5e-10 cgdo=1.5e-10 cgbo=1e-11 jss=1e-4 cjs=1e-3 cjsws=2e-10
.tran 10p 1.5n
.end
