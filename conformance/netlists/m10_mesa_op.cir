MESA level 2 operating point
vds 1 0 dc 0.5
vids 1 2 dc 0
vgs 3 0 dc 0
z1 2 3 0 mesmod l=1u w=20u
z2 2 3 0 mesmod2 l=2u w=40u
.model mesmod nmf(level=2)
.model mesmod2 nmf(level=2 rg=10)
.save all
.options reltol=1e-9 vntol=1e-12 abstol=1e-15
.op
.end
