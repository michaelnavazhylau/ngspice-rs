B-source operating point: functions, operators, parameters, .func and i()
* Nonlinear B sources over node voltages and branch currents (#79). The
* inpptree.c function set, C's comparison/logical/ternary operators, a .param
* and a .func, the m/tc1/tc2/temp setters and a sensed B branch current.
.param gain=2.5 vt=0.025
.func softclip(x) {tanh(x)*1.5}
vin in 0 dc 0.8
rin in 0 1k
vb b 0 dc -0.3
rb b 0 2k
b1 o1 0 v=gain*v(in)^2 - sqrt(abs(v(b))) + exp(v(in,b))
r1 o1 0 1k
b2 o2 0 i=1m*softclip(v(in)/vt*0.01) + i(vin)*0.5
r2 o2 0 2k
b3 o3 0 v=v(in) > 0.5 ? log(1+v(in)) : atan(v(b)) m=2
r3 o3 0 1k
b4 o4 0 v=pwl(v(in), -1,-2, 0,0, 1,3, 2,3.5) + min(v(in),v(b)) + max(v(in), 2*v(b))
r4 o4 0 1k
b5 o5 0 v=sin(v(in))*cos(v(b)) + sinh(v(b)) + cosh(v(in)/2) + tan(v(in)/3) + asinh(v(b)) + acos(v(b)) + asin(v(in)/2) + atan(v(in))
r5 o5 0 1k
b6 o6 0 v=u(v(in)-0.5) + uramp(v(in)-0.2) + u2(v(in)) + sgn(v(b)) + floor(3.7*v(in)) + ceil(v(b)) + nint(2.5) + pow(v(in),1.5) + pwr(v(b),2) + log10(v(in)+1) + ln(2) + acosh(2+v(in)) + atanh(v(b))
r6 o6 0 1k
b7 0 o7 i=v(o1)/2k tc1=1m tc2=1e-6 temp=50
r7 o7 0 1k
b8 o8 0 v=v(o7)*temper/27 + pi + e + (v(in)<1 && v(b)<0) + (v(b)>=0 || v(in)<=1) + (v(in)<>v(b))
r8 o8 0 1k
b9 o9 0 v=i(b1)*1k + v(o1)**2/10 + v(in)^v(o3) + 2^v(b)
r9 o9 0 1k
.op
.end
