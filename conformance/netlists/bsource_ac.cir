B-source AC: small-signal linearisation at the bias point
* Nonlinear B sources biased by DC and driven by an AC source: the AC
* response uses their Jacobian at the operating point (asrcacld.c), for a
* voltage output (a squarer driving an RC) and a current output (an
* exponential transconductor into an RC), plus a sensed branch current (#79).
vin in 0 dc 0.6 ac 1
rin in 0 1k
b1 sq 0 v=v(in)^2*3 + 0.5*sin(v(in))
r1 sq out1 1k
c1 out1 0 100n
b2 0 out2 i=1e-6*exp(v(in)/0.1) + 2m*v(out1)
r2 out2 0 1k
c2 out2 0 47n
b3 cur 0 v=i(vin)*1k*v(in)
r3 cur 0 1k
.ac dec 5 10 1meg
.end
