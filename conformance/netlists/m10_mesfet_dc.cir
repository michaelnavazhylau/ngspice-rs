MESFET level 1 output/transfer sweep: Statz B/ALPHA/LAMBDA, RD/RS, inverse mode, area/m, PMF
vds d 0 0
vgs g 0 0
z1 d g 0 zn
vds2 d2 0 0
vgs2 g2 0 0.5
z2 d2 g2 0 zp area=2 m=3
vds3 d3 0 0
z3 d3 g s3 zt area=0.5
vs3 s3 0 0.3
.model zn nmf(vto=-1.8 beta=3m lambda=0.05 alpha=2.5 b=0.4 rd=20 rs=15 is=1e-14 cgs=1p cgd=0.3p)
.model zp pmf(vto=-1.5 beta=2m lambda=0.02 b=0.1 alpha=3 rs=10)
.model zt nmf(level=1 vt0=-1 vto=-1.6 beta=4m alpha=1.5 rd=5 pmf nmf)
.options reltol=1e-7 vntol=1e-12 abstol=1e-15
.dc vds -2 6 0.25 vgs -2.5 0.5 0.5
.end
