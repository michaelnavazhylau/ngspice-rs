BJT Ebers Moll charge companion transient
vcc vcc 0 5
vin in 0 pulse(0.55 0.65 10n 10n 10n 30n 80n)
rb in base 1k
rc vcc coll 1k
q1 coll base 0 qm
.model qm npn(is=1e-14 bf=100 cje=20p cjc=5p tf=1n)
.tran 1n 100n 0 0.1n
.end
