HFET2 level 6 pole-zero: common-source stage with a current drive at the gate
vdd vdd 0 3
vin gate 0 dc -0.5 ac 1
rs gate g 1k
rd vdd drain 100
cl drain 0 1p
z1 drain g 0 h2 l=1u w=20u
.model h2 nhfet level=6 rd=31 rs=31 rdi=50 rsi=50 js=1e-12
.pz g 0 drain 0 cur pz
.end
