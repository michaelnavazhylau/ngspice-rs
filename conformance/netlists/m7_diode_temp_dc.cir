Diode temperature sweep: EG/XTI/TNOM, TLEV 2 band gap, DTEMP and breakdown TCV
.options reltol=1e-6
i1 0 a dc 1m
d1 a 0 dsi
i2 0 b dc 1m
d2 b 0 dtl2 dtemp=10
v3 c 0 dc 9
r3 c k 1k
d3 0 k dz
.model dsi d(is=2e-14 n=1.05 eg=1.11 xti=3 tnom=35 rs=5 trs1=3m)
.model dtl2 d(is=1e-15 n=1.2 tlev=2 eg=1.17 gap1=4.73e-4 gap2=636 xti=2.5 isr=1e-12 nr=2)
.model dz d(bv=5.6 ibv=1m tcv=2.5m nbv=1.2)
.dc temp -40 125 5
.end
