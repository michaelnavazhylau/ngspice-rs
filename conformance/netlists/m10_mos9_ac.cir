MOS9 small signal: active-load common-source stage, Meyer and junction charge at 75 C
vdd vdd 0 5
vin gate 0 dc 1.15 ac 1
vbias pg 0 3.6
m1 drain gate 0 0 mn w=8u l=1.4u m=2 ad=24p as=24p pd=22u ps=22u
m2 drain pg vdd vdd mp w=16u l=1.4u ad=48p as=48p pd=38u ps=38u dtemp=-10
cl drain 0 50f
.model mn nmos(level=9 vto=0.75 tox=20n nsub=1.2e16 xj=0.25u ld=0.1u uo=520 vmax=1.2e5
+ nfs=1e11 eta=0.25 theta=0.07 kappa=0.4 delta=0.5 cgso=0.4n cgdo=0.4n cgbo=0.2n
+ cj=0.5m cjsw=0.4n mjsw=0.33 rd=40 rs=30)
.model mp pmos(level=9 vto=-0.85 tox=20n nsub=1.5e16 xj=0.25u ld=0.1u uo=210 vmax=1e5
+ eta=0.2 theta=0.1 kappa=0.5 cgso=0.4n cgdo=0.4n cgbo=0.2n cj=0.6m cjsw=0.45n js=1e-4)
* RELTOL is tightened so that C's own Newton stopping error at the bias
* point stays below the 1 ppm small-signal bound (as in m10_mos3_ac).
.options temp=75 reltol=1e-7 vntol=1e-12 abstol=1e-18
.ac dec 5 1k 10g
.end
