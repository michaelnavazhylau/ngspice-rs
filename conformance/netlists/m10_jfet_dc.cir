JFET level 1 output/transfer sweep: Sydney B tail, RD/RS, inverse mode, area/m, PJF
vds d 0 0
vgs g 0 0
j1 d g 0 jn
vds2 d2 0 0
vgs2 g2 0 0.5
j2 d2 g2 0 jp 2 m=3
vds3 d3 0 0
j3 d3 g s3 jt area=0.5
vs3 s3 0 0.3
.model jn njf(vto=-2 beta=1.2m lambda=0.03 rd=20 rs=15 is=1e-14 n=1.1 b=0.7 cgs=2p cgd=1p)
.model jp pjf(vto=-1.5 beta=0.8m lambda=0.02 b=1.2 rs=10)
.model jt njf(level=1 vt0=-1 vto=-1.8 beta=2m b=1 rd=5 pjf njf)
.options reltol=1e-7 vntol=1e-12 abstol=1e-15
.dc vds -2 6 0.25 vgs -2.5 0.5 0.5
.end
