Series RLC pulse transient, Gear maxord=6
* Same circuit and drive as rlc_series_gear_tran with maxord=6 (#98).
* dctran.c only ever raises the integration order from 1 to 2, so ngspice
* (and the port) integrate exactly as with the default maxord=2.
v1 in 0 pulse(0 1 50u 20u 20u 400u 1m)
r1 in a 10
l1 a out 1m
c1 out 0 1u
.options method=gear maxord=6
.tran 1u 1m
.end
