B-source zero start: singular slopes swept from a 0 V Newton start
* The first sweep point starts Newton at 0 V, where the 1/x, sqrt, log and
* division slopes are about 1e32 (C's PTdivide fudge) or log() is -1e99
* (#79); later points start from the previous solution.
vin in 0 dc 1
rin in mid 1k
rmid mid 0 3k
b1 o1 0 v=1/v(in)
r1 o1 0 1k
b2 o2 0 v=sqrt(v(mid))*log(v(in))
r2 o2 0 1k
b3 0 o3 i=1m*(v(in)/v(mid) + log10(v(mid)))
r3 o3 0 1k
.dc vin 0.5 3 0.25
.end
