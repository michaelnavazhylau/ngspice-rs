TXL Pade transient: a tmax above taul, which C clamps to 0.9*taul
v1 1 0 dc 0 pulse(0 1 2n 0.1n 0.1n 100n 200n)
y1 1 0 2 0 ym
rl 2 0 50
.model ym txl r=1 l=250e-9 c=100e-12 g=0 length=1
.options reltol=1e-6 vntol=1e-9 abstol=1e-14
.tran 0.5n 50n 0 10n
.end
