HFET2 level 6 operating point: both polarities and every resistance
vdd 1 0 dc 3
vgg 2 0 dc 0.4
vgg2 4 0 dc -0.4
z1 1 2 0 n2 l=1u w=10u
z2 3 4 0 p2 l=1u w=10u
.model n2 nhfet level=6 rd=31 rs=31 rdi=50 rsi=50 js=1e-6
.model p2 phfet level=6 rd=31 rs=31 js=1e-6
.save all
.options reltol=1e-9 vntol=1e-12 abstol=1e-15
.op
.end
