RC low-pass, AC sweep
v1 in 0 dc 0 ac 1
r1 in out 1k
c1 out 0 1u
.ac lin 3 100 1k
.end
