TXL Pade path: the DC stamp of a 138.5 ohm line
v1 1 0 dc 5
y1 1 0 2 0 ym
rl 2 0 50
.model ym txl r=12.45 l=8.972e-9 c=0.468e-12 g=0 length=16
.options reltol=1e-9 vntol=1e-12 abstol=1e-15
.op
.end
