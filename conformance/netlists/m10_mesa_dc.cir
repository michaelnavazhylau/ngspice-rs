MESA level 2 gate sweep
vds 1 0 dc 0.5
vids 1 2 dc 0
vgs 3 0 dc -1.2
z1 2 3 0 mesmod l=1u w=20u
.model mesmod nmf(level=2)
.save all
.options reltol=1e-9 vntol=1e-12 abstol=1e-15
.dc vgs -1.2 0 0.6
.end
