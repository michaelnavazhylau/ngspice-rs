RC driven by a piecewise-linear source
* tau = 1 ms. Corners at 1 ms, 1.1 ms, 3 ms and 3.1 ms (all on the 10 us grid).
v1 in 0 pwl(0 0 1m 0 1.1m 1 3m 1 3.1m 0.25 8m 0.25)
r1 in out 1k
c1 out 0 1u
.tran 10u 8m
.end
