Linear controlled sources AC sweep
* E: inverting integrator (op-amp gain 1e4) driving a G transconductor into an
* RC load; vs senses the load current for an F and an H.
vin in 0 dc 0 ac 1
r1 in inv 1k
c1 inv out 1u
e1 out 0 0 inv 1e4
g1 0 o2 out 0 1m
c2 o2 0 1u
r2 o2 0 1k
vs o2 o3 0
r3 o3 0 1k
f1 0 o4 vs 2
r4 o4 0 1k
h1 o5 0 vs 100
r5 o5 0 1k
.ac lin 20 100 2k
.end
