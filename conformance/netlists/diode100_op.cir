Diode chain operating point (100 junctions, MODEINITJCT start, pnjlim)
* M10 0.5h: long diode chains once failed .op where ngspice converges.
* 100 stages of 100 ohm and a 1e-14 A diode from 100 V into 1 kohm: every
* junction conducts (about 2.9 mA), so ngspice's direct Newton result is
* well conditioned. The 5 V benchmark chain (current below ABSTOL) is pinned
* against C in tests/convergence.rs instead.
V1 n0 0 DC 100
.model D1 D(IS=1e-14 N=1)
R0 n0 m0 100
D0 m0 n1 D1
R1 n1 m1 100
D1 m1 n2 D1
R2 n2 m2 100
D2 m2 n3 D1
R3 n3 m3 100
D3 m3 n4 D1
R4 n4 m4 100
D4 m4 n5 D1
R5 n5 m5 100
D5 m5 n6 D1
R6 n6 m6 100
D6 m6 n7 D1
R7 n7 m7 100
D7 m7 n8 D1
R8 n8 m8 100
D8 m8 n9 D1
R9 n9 m9 100
D9 m9 n10 D1
R10 n10 m10 100
D10 m10 n11 D1
R11 n11 m11 100
D11 m11 n12 D1
R12 n12 m12 100
D12 m12 n13 D1
R13 n13 m13 100
D13 m13 n14 D1
R14 n14 m14 100
D14 m14 n15 D1
R15 n15 m15 100
D15 m15 n16 D1
R16 n16 m16 100
D16 m16 n17 D1
R17 n17 m17 100
D17 m17 n18 D1
R18 n18 m18 100
D18 m18 n19 D1
R19 n19 m19 100
D19 m19 n20 D1
R20 n20 m20 100
D20 m20 n21 D1
R21 n21 m21 100
D21 m21 n22 D1
R22 n22 m22 100
D22 m22 n23 D1
R23 n23 m23 100
D23 m23 n24 D1
R24 n24 m24 100
D24 m24 n25 D1
R25 n25 m25 100
D25 m25 n26 D1
R26 n26 m26 100
D26 m26 n27 D1
R27 n27 m27 100
D27 m27 n28 D1
R28 n28 m28 100
D28 m28 n29 D1
R29 n29 m29 100
D29 m29 n30 D1
R30 n30 m30 100
D30 m30 n31 D1
R31 n31 m31 100
D31 m31 n32 D1
R32 n32 m32 100
D32 m32 n33 D1
R33 n33 m33 100
D33 m33 n34 D1
R34 n34 m34 100
D34 m34 n35 D1
R35 n35 m35 100
D35 m35 n36 D1
R36 n36 m36 100
D36 m36 n37 D1
R37 n37 m37 100
D37 m37 n38 D1
R38 n38 m38 100
D38 m38 n39 D1
R39 n39 m39 100
D39 m39 n40 D1
R40 n40 m40 100
D40 m40 n41 D1
R41 n41 m41 100
D41 m41 n42 D1
R42 n42 m42 100
D42 m42 n43 D1
R43 n43 m43 100
D43 m43 n44 D1
R44 n44 m44 100
D44 m44 n45 D1
R45 n45 m45 100
D45 m45 n46 D1
R46 n46 m46 100
D46 m46 n47 D1
R47 n47 m47 100
D47 m47 n48 D1
R48 n48 m48 100
D48 m48 n49 D1
R49 n49 m49 100
D49 m49 n50 D1
R50 n50 m50 100
D50 m50 n51 D1
R51 n51 m51 100
D51 m51 n52 D1
R52 n52 m52 100
D52 m52 n53 D1
R53 n53 m53 100
D53 m53 n54 D1
R54 n54 m54 100
D54 m54 n55 D1
R55 n55 m55 100
D55 m55 n56 D1
R56 n56 m56 100
D56 m56 n57 D1
R57 n57 m57 100
D57 m57 n58 D1
R58 n58 m58 100
D58 m58 n59 D1
R59 n59 m59 100
D59 m59 n60 D1
R60 n60 m60 100
D60 m60 n61 D1
R61 n61 m61 100
D61 m61 n62 D1
R62 n62 m62 100
D62 m62 n63 D1
R63 n63 m63 100
D63 m63 n64 D1
R64 n64 m64 100
D64 m64 n65 D1
R65 n65 m65 100
D65 m65 n66 D1
R66 n66 m66 100
D66 m66 n67 D1
R67 n67 m67 100
D67 m67 n68 D1
R68 n68 m68 100
D68 m68 n69 D1
R69 n69 m69 100
D69 m69 n70 D1
R70 n70 m70 100
D70 m70 n71 D1
R71 n71 m71 100
D71 m71 n72 D1
R72 n72 m72 100
D72 m72 n73 D1
R73 n73 m73 100
D73 m73 n74 D1
R74 n74 m74 100
D74 m74 n75 D1
R75 n75 m75 100
D75 m75 n76 D1
R76 n76 m76 100
D76 m76 n77 D1
R77 n77 m77 100
D77 m77 n78 D1
R78 n78 m78 100
D78 m78 n79 D1
R79 n79 m79 100
D79 m79 n80 D1
R80 n80 m80 100
D80 m80 n81 D1
R81 n81 m81 100
D81 m81 n82 D1
R82 n82 m82 100
D82 m82 n83 D1
R83 n83 m83 100
D83 m83 n84 D1
R84 n84 m84 100
D84 m84 n85 D1
R85 n85 m85 100
D85 m85 n86 D1
R86 n86 m86 100
D86 m86 n87 D1
R87 n87 m87 100
D87 m87 n88 D1
R88 n88 m88 100
D88 m88 n89 D1
R89 n89 m89 100
D89 m89 n90 D1
R90 n90 m90 100
D90 m90 n91 D1
R91 n91 m91 100
D91 m91 n92 D1
R92 n92 m92 100
D92 m92 n93 D1
R93 n93 m93 100
D93 m93 n94 D1
R94 n94 m94 100
D94 m94 n95 D1
R95 n95 m95 100
D95 m95 n96 D1
R96 n96 m96 100
D96 m96 n97 D1
R97 n97 m97 100
D97 m97 n98 D1
R98 n98 m98 100
D98 m98 n99 D1
R99 n99 m99 100
D99 m99 n100 D1
Rl n100 0 1k
.op
.end
