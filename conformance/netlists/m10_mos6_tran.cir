MOS6 CMOS inverter: Meyer gate charge, junction charge, series resistance
vdd vdd 0 3.3
vin in 0 pulse(0 3.3 1n 0.5n 0.5n 4n 10n)
mn out in 0 0 nch w=2u l=0.5u ad=2p as=2p pd=6u ps=6u nrd=2 nrs=2
mp out in vdd vdd pch w=5u l=0.5u ad=5p as=5p pd=12u ps=12u
cl out 0 20f
* As m10_mos3_tran: trapezoidal integration at the default RELTOL leaves the
* gate current 2.9x the bound apart at the 11 ns edge; Gear-2 verifies at 0.6
* of the bound, and reltol=1e-5 with the bounded step at 0.008.
.model nch nmos(level=6 vto=0.65 tox=9n u0=450 kv=1.1 nv=0.7 nc=1.3 gamma=0.4 phi=0.75
+ sigma=0.01 lambda0=0.04 cgso=0.3n cgdo=0.3n cgbo=0.1n cj=0.9m mj=0.5 cjsw=0.25n pb=0.9
+ rsh=20 js=1e-4)
.model pch pmos(level=6 vto=-0.75 tox=9n u0=180 kv=1.4 nv=0.6 nc=1.25 gamma=0.45
+ lambda0=0.05 cgso=0.3n cgdo=0.3n cgbo=0.1n cj=1m cjsw=0.3n mjsw=0.33 pb=0.9 rd=30 rs=30)
.options method=gear reltol=1e-5
.tran 0.05n 20n 0 2p
.end
