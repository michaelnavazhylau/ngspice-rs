TXL three-pi fallback: a high R/L line expands into an R/C ladder
v1 1 0 dc 5
y1 1 0 2 0 ym
rl 2 0 1k
.model ym txl r=1e9 l=1e-2 c=1e-9 g=0 length=3e-11
.options reltol=1e-9 vntol=1e-12 abstol=1e-15
.op
.end
