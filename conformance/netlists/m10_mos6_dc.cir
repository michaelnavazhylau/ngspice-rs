MOS6 DC: n-th power law, GAMMA1/SIGMA/LAMBDA1 threshold and CLM terms, process, temperature
vgs g 0 0
vd1 d1 0 3
vd2 d2 0 0.2
vd4 d4 0 -0.5
vbn bn 0 -1
vbf bf 0 0.3
vbp bp 0 -0.4
egp gp 0 g 0 -1
m1 d1 g 0 bn mfull w=10u l=1u
m2 d2 g 0 0 mproc w=10u l=1.2u
m3 d3 gp 0 bp mp w=20u l=1u temp=60 nrd=2 nrs=2
m4 d4 g 0 0 mfull w=10u l=1u
m5 d1 g 0 bf mfull w=4u l=2u m=2
m6 g g 0 bn mlam w=5u l=0.8u
vd3 d3 0 -2.5
.model mfull nmos(level=6 vto=0.7 kv=1.8 nv=0.9 kc=6e-5 nc=1.25 gamma=0.5 gamma1=0.03
+ sigma=0.02 phi=0.7 lambda0=0.04 lambda1=0.01 ld=0.08u)
.model mproc nmos(level=6 tox=25n nsub=2e16 tpg=1 nss=1e10 uo=500 kv=1.2 nv=0.7 nc=1.4
+ lambda=0.03 tnom=20)
.model mp pmos(level=6 vto=-0.8 tox=20n u0=220 kv=2.2 nv=0.6 nc=1.2 gamma=0.4 sigma=0.01
+ lambda0=0.05 rd=20 rsh=15 ld=0.06u)
.model mlam nmos(level=6 vt0=0.6 kc=8e-5 nc=1.1 kv=1.5 nv=0.5 gamma=0.4 phi=0.65 gamma1=0.02
+ lambda0=0.05 lambda1=0.02 sigma=0.03 is=1e-15)
.options reltol=1e-7 vntol=1e-12 abstol=1e-18
.dc vgs 0 4 0.05
.end
