RC discharge from an initial capacitor voltage, uic
* c1 starts at 2 V (instance ic=) and discharges through r1 into the 0 V source:
* v(out) = 2 exp(-t/tau), tau = 1 ms. With uic there is no operating-point solve
* and no t = 0 row; C adds a breakpoint at the .tran step (10 us).
v1 in 0 dc 0
r1 in out 1k
c1 out 0 1u ic=2
.tran 10u 5m uic
.end
