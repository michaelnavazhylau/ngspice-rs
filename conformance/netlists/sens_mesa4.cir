DC sensitivity of a MESA level-4 device (#164)
* `sens_mesa.cir` senses the level-2 gate node, whose ~1 uV swing makes every
* row a cancellation-limited difference; this fixture senses the drain current
* instead, which is O(mA), so a level-4 row can be compared directly. The bias
* is well inside the saturated region: near cut-off the model's exponential
* tails make `.sens`'s linearisation differ from a re-solved operating point by
* orders of magnitude, which is a property of the stamp, not of either
* implementation.
*
* PHIB is the electron-volt value the barrier needs, for the reason spelled out
* in `sens_mesa.cir`: `mesamparam.c` stores PHIB*CHARGE while `mesamask.c`
* returns the stored joules, so the walk restores PHIB*CHARGE**2.
.options reltol=1e-10 vntol=1e-13 abstol=1e-16
vds 1 0 dc 1.0
vids 1 2 dc 0
vgs 4 0 dc 0.5
rg 4 3 1k
z1 2 3 0 mesmod4 l=1u w=20u
.model mesmod4 nmf(level=4 rd=31 rs=31 rdi=20 rsi=20 mu=0.3 gamma=2.5
+ nmax=4e16 cas=0.9 cbs=1.1 epsi=1.142189e-10 phib=3.1232e18)
.sens i(vids)
.end
