JFET level 2 common-source amplifier: Parker-Skellern dispersion (TAUG/TAUD), Statz charge, CDS, RD/RS, area and m
vdd vdd 0 12
vin in 0 dc -0.6 ac 1
rg in g 10k
rl vdd d 2.2k
rsrc s 0 200
cs s 0 10u
j1 d g s jn 2 m=2
.model jn njf(level=2 vto=-2.2 beta=1.2m lambda=0.02 rd=15 rs=10 cgs=3p cgd=1p cds=0.2p acgam=0.1 xc=0.2 pb=0.8 fc=0.5 delta=0.2 taud=1u lfgam=0.04 lfg1=0.01 lfg2=0.005 hfgam=0.02 hfg1=0.01 hfg2=0.004 hfeta=0.03 hfe1=0.01 hfe2=0.005 taug=10u vst=0.08 mvst=0.05 p=2.1 q=2 xi=20 z=0.6 is=2e-14 n=1.1)
.options reltol=1e-7 vntol=1e-12 abstol=1e-15
.ac dec 10 1 1g
.end
