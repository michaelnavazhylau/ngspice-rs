Matched 50 ohm T attenuator, S-parameters
* K = 3 (9.54 dB): series arms Z0 (K-1)/(K+1) = 25, shunt 2 Z0 K/(K^2-1) = 37.5.
v1 in 0 dc 0 ac 1 portnum 1 z0 50
r1 in mid 25
r2 mid 0 37.5
r3 mid out 25
v2 out 0 dc 0 ac 0 portnum 2 z0 50
.sp lin 3 1k 1meg
.end
