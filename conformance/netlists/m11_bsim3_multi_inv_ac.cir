BSIM3v3.3 multi-instance: inv ac
* #189/#193: C's per-model BSIM3 state across instances.
* The inverter chain, AC with its input at mid-supply.
vdd dd 0 1.8
vin in 0 dc 0.9 ac 1 pulse(0 1.8 0.1n 50p 50p 0.4n 1n)
mp1 o1 in dd dd p3 l=0.18u w=4u ad=2p as=2p pd=6u ps=6u
mn1 o1 in 0 0 n3 l=0.18u w=2u ad=1p as=1p pd=4u ps=4u
c1 o1 0 5f
mp2 o2 o1 dd dd p3 l=0.18u w=4u ad=2p as=2p pd=6u ps=6u
mn2 o2 o1 0 0 n3 l=0.18u w=2u ad=1p as=1p pd=4u ps=4u
c2 o2 0 5f
mp3 o3 o2 dd dd p3 l=0.18u w=4u ad=2p as=2p pd=6u ps=6u
mn3 o3 o2 0 0 n3 l=0.18u w=2u ad=1p as=1p pd=4u ps=4u
c3 o3 0 5f
.model n3 nmos level=49 version=3.3.0 capmod=3 cgdo=-7.9e-10 cgso=-7.9e-10 cgbo=-1e-12 mobmod=1 tox=4.1e-9 xj=1e-7 nch=2.3549e17
+ vth0=0.3694 k1=0.5789 k2=1.10e-3 k3=1e-3 k3b=0.0295 w0=1e-7 nlx=1.919e-7 dvt0w=0
+ dvt1w=0 dvt2w=0 dvt0=1.0471 dvt1=0.3896 dvt2=0.0367 u0=268.7 ua=-1.39e-9 ub=2.34e-18
+ uc=5.42e-11 vsat=1.07e5 a0=1.9 ags=0.42 b0=-1.3e-8 b1=-1e-7 keta=-8.6e-3 a1=1.4e-4
+ a2=0.69 rdsw=105 prwg=0.5 prwb=-0.2 wr=1 wint=0 lint=1.69e-8 dwg=-5.6e-9 dwb=6.1e-9
+ voff=-0.0886 nfactor=2.2 cit=0 cdsc=2.4e-4 cdscd=0 cdscb=0 eta0=2.74e-3 etab=6.39e-5
+ dsub=0.0156 pclm=0.739 pdiblc1=0.209 pdiblc2=2.62e-3 pdiblcb=-0.1 drout=0.79
+ pscbe1=8.2e9 pscbe2=1.1e-8 pvag=2.4e-2 delta=0.01 rsh=6.8 prt=0 ute=-1.5 kt1=-0.11
+ kt1l=0 kt2=0.022 ua1=4.31e-9 ub1=-7.61e-18 uc1=-5.6e-11 at=3.3e4 cgdo=7.9e-10
+ cgso=7.9e-10 cgbo=1e-12 cj=9.7e-4 pb=0.73 mj=0.36 cjsw=2.4e-10 pbsw=0.4 mjsw=0.1
+ cjswg=3.3e-10 pbswg=0.4 mjswg=0.1 cf=0 xpart=0.5
.model p3 pmos level=49 version=3.3.0 capmod=3 a2=1.2 rdsw=-10 prwg=-1 mobmod=1 tox=4.1e-9 xj=1e-7 nch=2.3549e17
+ vth0=-0.39 k1=0.5789 k2=1.10e-3 k3=1e-3 k3b=0.0295 w0=1e-7 nlx=1.919e-7 dvt0w=0
+ dvt1w=0 dvt2w=0 dvt0=1.0471 dvt1=0.3896 dvt2=0.0367 u0=110 ua=-1.39e-9 ub=2.34e-18
+ uc=5.42e-11 vsat=1.07e5 a0=1.9 ags=0.42 b0=-1.3e-8 b1=-1e-7 keta=-8.6e-3 a1=1.4e-4
+ a2=0.69 rdsw=105 prwg=0.5 prwb=-0.2 wr=1 wint=0 lint=1.69e-8 dwg=-5.6e-9 dwb=6.1e-9
+ voff=-0.0886 nfactor=2.2 cit=0 cdsc=2.4e-4 cdscd=0 cdscb=0 eta0=2.74e-3 etab=6.39e-5
+ dsub=0.0156 pclm=0.739 pdiblc1=0.209 pdiblc2=2.62e-3 pdiblcb=-0.1 drout=0.79
+ pscbe1=8.2e9 pscbe2=1.1e-8 pvag=2.4e-2 delta=0.01 rsh=6.8 prt=0 ute=-1.5 kt1=-0.11
+ kt1l=0 kt2=0.022 ua1=4.31e-9 ub1=-7.61e-18 uc1=-5.6e-11 at=3.3e4 cgdo=7.9e-10
+ cgso=7.9e-10 cgbo=1e-12 cj=9.7e-4 pb=0.73 mj=0.36 cjsw=2.4e-10 pbsw=0.4 mjsw=0.1
+ cjswg=3.3e-10 pbswg=0.4 mjswg=0.1 cf=0 xpart=0.5
.options reltol=1e-9 vntol=1e-12 abstol=1e-15
.ac dec 3 1meg 10g
.end
