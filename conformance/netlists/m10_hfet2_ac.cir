HFET2 level 6 small-signal sweep
vds 1 0 dc 2.0 ac 1
vids 1 2 dc 0
vgs 3 0 dc 0.6
z1 2 3 0 h2 l=1u w=10u
.model h2 nhfet level=6 rd=60 rs=60 js=1e-6
.save all
.options reltol=1e-9 vntol=1e-12 abstol=1e-15
.ac dec 2 1k 1meg
.end
