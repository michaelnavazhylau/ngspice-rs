Noise of MOS1 stages with every NLEV flicker law
* #100: mos1noi.c rd/rs/id thermal and the NLEV 0/1/2/3 flicker laws, a PMOS
* load at its own temp= and a differential output.
vdd vdd 0 5
v1 in 0 dc 2 ac 1
m1 out in 0 0 nm0 w=10u l=2u
m2 out in vdd vdd pm3 w=20u l=2u temp=50
m3 o2 in 0 0 nm1 w=10u l=2u m=2
m4 o2 in 0 0 nm3 w=5u l=1u
m5 o2 in 0 0 nm2 w=4u l=1u
r1 vdd out 10k
r2 vdd o2 20k
.model nm0 nmos(vto=1 kp=1e-4 kf=1e-24 af=1.3 nlev=0)
.model nm1 nmos(vto=0.8 kp=1e-4 kf=1e-24 af=1.1 nlev=1 tox=1e-8)
.model nm2 nmos(vto=0.9 kp=1e-4 kf=1e-25 af=0.9 rd=20 rs=10 tox=2e-8 cgso=1n cgdo=1n)
.model nm3 nmos(vto=0.8 kp=1e-4 kf=1e-24 af=1.1 nlev=3 gdsnoi=2 lambda=0.01)
.model pm3 pmos(vto=-1 kp=5e-5 kf=1e-24 nlev=3 rd=20 rs=10)
.noise v(out,o2) v1 lin 6 1k 100k 1
.end
