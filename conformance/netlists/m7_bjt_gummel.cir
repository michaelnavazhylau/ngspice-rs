Gummel-Poon BJT Gummel plot
vbe b 0 0.5
vcb c b 0
q1 c b 0 qgp
.model qgp npn(is=2e-16 bf=150 nf=1.01 vaf=60 ikf=20m ise=5e-14 ne=1.7 br=4 nr=1.02 var=8 ikr=2m isc=1e-13 nc=1.9 rb=150 irb=0.2m rbm=15 re=1.5 rc=20)
.options reltol=1e-8
.dc vbe 0.3 1.1 0.02
.end
