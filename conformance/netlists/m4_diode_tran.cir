Diode charge companion transient
v1 in 0 pulse(0.5 0.7 10n 10n 10n 30n 80n)
r1 in out 1k
d1 out 0 dm
.model dm d(is=1e-14 n=1 rs=10 cjo=20p vj=0.7 m=0.5 tt=1n)
.tran 1n 100n 0 0.1n
.end
