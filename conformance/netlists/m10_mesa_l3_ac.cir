MESA level 3 small-signal sweep
vds 1 0 dc 2.0 ac 1
vids 1 2 dc 0
vgs 3 0 dc 0.5
z1 2 3 0 m3 l=1u w=20u
.model m3 nmf level=3 rd=31 rs=31 mu=0.25 vto=-1 eta=1.5 sigma0=0.02
+ vsigmat=1.37 delta=5 beta=0.0085
.save all
.options reltol=1e-9 vntol=1e-12 abstol=1e-15
.ac dec 2 1k 1meg
.end
