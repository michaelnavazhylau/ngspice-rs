DC sensitivity of a MESA level-4 device at a shifted instance temperature (#164)
* The case that used to be refused: `rtc1`/`rtc2` came out at 0.808x C's while
* every other column agreed to 1e-6, because `mesaload.c`'s `mesa3` uses the
* temperature-scaled `RS` (`here->MESAtRsi`) in `p` and in `delisatmgchim`
* while the port read the raw `model.rsi`. `TS` is the instance temperature
* the gap was measured at; the bias and the `i(vids)` output follow
* `sens_mesa4`, and the pair `rtc1`/`rtc2` is what the model library needs for
* a hot device.
*
* PHIB is the electron-volt value the barrier needs (`sens_mesa.cir`).
.options reltol=1e-10 vntol=1e-13 abstol=1e-16
vds 1 0 dc 1.0
vids 1 2 dc 0
vgs 4 0 dc 0.5
rg 4 3 1k
z1 2 3 0 mesmod4 l=1u w=20u ts=40
.model mesmod4 nmf(level=4 rd=31 rs=31 rdi=20 rsi=20 mu=0.3 gamma=2.5 nmax=4e16
+ cas=0.9 cbs=1.1 epsi=1.142189e-10 phib=3.1232e18 rtc1=1e-3 rtc2=1e-5)
.sens i(vids)
.end
