MESA level 3 drain sweep across the two-population threshold regions
z1 3 2 0 mesmod l=1u w=150u
vgs 2 0 dc -1
vds 1 0 dc 0
vids 1 3 dc 0
.model mesmod nmf level=3 rdi=2.7 rsi=2.7 mu=0.2 m=2.2 vto=-2.04
+ eta=1.5 lambda=0.04 tc=0.001 sigma0=0.02 vsigma=0.1 vsigmat=1.37
+ delta=5 beta=0.0085 ndu=1e22 ndelta=6e24 du=0.035e-6 th=0.01e-6
.save all
.options reltol=1e-9 vntol=1e-12 abstol=1e-15
.dc vds 0 4 0.1
.end
