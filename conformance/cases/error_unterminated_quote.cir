Unterminated quoted string
.include "missing.inc
.op
.end
