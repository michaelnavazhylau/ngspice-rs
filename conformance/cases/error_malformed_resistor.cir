Resistor with a missing value
v1 in 0 dc 1
r1 in
.op
.end
