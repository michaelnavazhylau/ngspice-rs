POLY controlled source without coefficients is an error
vin in 0 dc 1
* C: "Number of connections differs from poly dimension" (enhtrans.c).
e1 out 0 poly(1) in 0
r1 out 0 1k
.op
.end
