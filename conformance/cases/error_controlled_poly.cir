POLY controlled source is not yet ported
vin in 0 dc 1
* POLY(n) is rewritten by inpcom.c/XSPICE in C; the port reports it explicitly.
e1 out 0 poly(1) in 0 0 2
r1 out 0 1k
.op
.end
