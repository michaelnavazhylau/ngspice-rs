Malformed expression
.param x = {1 +* 2}
.op
.end
