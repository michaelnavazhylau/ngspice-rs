Unmatched closing brace
r1 in 0 1k}
.op
.end
