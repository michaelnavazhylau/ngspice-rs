Options, globals and duplicate setters keep application order
.global vdd gnd
.option reltol=1e-4 gmin=1e-12 noopiter
.options reltol=1e-5
v1 vdd 0 dc 1 dc 2
r1 vdd 0 1k tc1=1 tc1=2
.op
.end
